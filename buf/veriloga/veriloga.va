// VerilogA for buf

`include "constants.vams"
`include "disciplines.vams"

//
// Module Name          : buf
// Library Name         : myVeriloga
// Test Bench           :
//
// Modification History :
//
//   Ananth : 6/28/2012 : v1.0: Copy of myVeriloga/inv
//

module buf(y, a);
  output     y;
  electrical y;
  input      a;
  electrical a;

  parameter real tdelr  = 100.0p from [0.0:inf);
  parameter real tdelf  = 100.0p from [0.0:inf);
  parameter real trise = 100.0p from [0.0:inf);
  parameter real tfall = 100.0p from [0.0:inf);
  parameter real vtrans   = 1.0;
parameter real vlogic_high = 5;
parameter real vlogic_low = 0;

  real    vout_val;
  real    delay;
  integer A;

  analog begin
      @ ( initial_step ) begin
	    if (vlogic_high < vlogic_low) begin
	       $display("Range specification error.  vlogic_high = (%E) less than vlogic_low = (%E).\n", vlogic_high, vlogic_low );
	       $finish;
	    end
	    if (vtrans > vlogic_high || vtrans < vlogic_low) begin
	       $display("Inconsistent $threshold specification w/logic family.\n");
	    end
      end

      A = V(a) > vtrans;

      @ (cross(V(a) - vtrans, 1))
      begin
          A = 1;
          delay = tdelr;
      end

      @ (cross(V(a) - vtrans, -1))
      begin
          A = 0;
          delay = tdelf;
      end

      // define the logic function.

      vout_val = A ? vlogic_high : vlogic_low;

      V(y) <+ transition( vout_val, delay, trise, tfall);

  end
endmodule
