// VerilogA for myVeriloga, nand3, veriloga

`include "constants.vams"
`include "disciplines.vams"

// $Date: 2012/6/24  $
// $Revision: 0.1 $
//
//
// Based on the ahdlLib nand_gate
//
//

//--------------------
// nand
//
// -  nand gate
//
// vin1, vin2, vin3:		[V,A]
// vout:		[V,A]
//
// INSTANCE parameters
//    vlogic_high = output voltage for high  [V]
//    vlogic_low   = output voltage for high  [V]
//    vtrans      = voltages above this at input are considered high  [V]
//    tdel, trise, tfall = {usual} [s]
//

module nand3 ( vout, vin1, vin2, vin3 );

  input vin2;
  input vin3;
  input vin1;
  output vout;

electrical vin1, vin2, vin3, vout;
parameter real vlogic_high = 5;
parameter real vlogic_low = 0;
parameter real vtrans = 1.4;
parameter real tdel = 2u from [0:inf);
parameter real trise = 1u from (0:inf);
parameter real tfall = 1u from (0:inf);

   real vout_val;
   integer logic1, logic2, logic3;

   analog begin

      @ ( initial_step ) begin
	 if (vlogic_high < vlogic_low) begin
	    $display("Range specification error.  vlogic_high = (%E) less than vlogic_low = (%E).\n", vlogic_high, vlogic_low );
	    $finish;
	 end
	 if (vtrans > vlogic_high || vtrans < vlogic_low) begin
	    $display("Inconsistent $threshold specification w/logic family.\n");
	 end
      end

      logic1 = V(vin1) > vtrans;
      logic2 = V(vin2) > vtrans;
      logic3 = V(vin3) > vtrans;

      @ (cross(V(vin1) - vtrans, 1))  logic1 = 1;
      @ (cross(V(vin1) - vtrans, -1)) logic1 = 0;

      @ (cross(V(vin2) - vtrans, 1))  logic2 = 1;
      @ (cross(V(vin2) - vtrans, -1)) logic2 = 0;

      @ (cross(V(vin3) - vtrans, 1))  logic3 = 1;
      @ (cross(V(vin3) - vtrans, -1)) logic3 = 0;

      //
      // define the logic function.
      //
      vout_val = !(logic1 && logic2 && logic3) ? vlogic_high : vlogic_low;

      V(vout) <+ transition( vout_val, tdel, trise, tfall);
   end
endmodule
