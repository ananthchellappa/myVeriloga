`include "discipline.h"
`include "constants.h"

// $Date: 1997/08/28 05:54:32 $
// $Revision: 1.1 $
//
//
// Based on the OVI Verilog-A Language Reference Manual, version 1.0 1996
//
//

//--------------------
// adc_8bit_ideal
//
// -  Ideal 8 bit analog to digital converter
//
// vin:		[V,A]
// vd0..vd7:	data output terminals	[V,A]
//
// INSTANCE parameters
//    tdel, trise, tfall = {usual} [s]
//    vlogic_high = [V]
//    vlogic_low  = [V]
//    vref        = voltage that voltage is done with respect to [V]
//
// MODEL parameters
//    {none}
//
// This model is ideal in the sense that there is no mismatch modeled.
//

module adc_8bit_noclk(vd7, vd6, vd5, vd4, vd3, vd2, vd1, vd0, vin);
electrical vd7, vd6, vd5, vd4, vd3, vd2, vd1, vd0, vin, vclk;
parameter real trise = 0 from [0:inf);
parameter real tfall = 0 from [0:inf);
parameter real tdel = 0 from [0:inf);
parameter real vlogic_high = 5;
parameter real vlogic_low  = 0;
parameter real vref        = 1.0;

`define NUM_ADC_BITS	8
   real unconverted;
   real halfref;

   real vd[0:`NUM_ADC_BITS-1];
   integer i;

   analog begin

// note : this was cooked up in a hurry, the outputs will only be set ONCE

      @ ( initial_step ) begin
          halfref = vref / 2;
         unconverted = V(vin);
         for (i = (`NUM_ADC_BITS-1); i >= 0 ; i = i - 1) begin
            vd[i] = 0;
            if (unconverted > halfref) begin
               vd[i] = vlogic_high;
               unconverted = unconverted - halfref;
	        end else begin
                vd[i] = vlogic_low;
	            end
            unconverted = unconverted * 2;
         end
      end // @ initial step

	 if( analysis( "static") )
	 begin
          halfref = vref / 2;
          unconverted = V(vin);
		  for (i = (`NUM_ADC_BITS-1); i >= 0 ; i = i - 1) begin
			 vd[i] = 0;
			 if (unconverted > halfref) begin
				vd[i] = vlogic_high;
				unconverted = unconverted - halfref;
		  end else begin
				 vd[i] = vlogic_low;
			  end
			 unconverted = unconverted * 2;
		  end
	 end // if analysis

      //
      // assign the outputs
      //
      V(vd7) <+ transition( vd[7], tdel, trise, tfall );
      V(vd6) <+ transition( vd[6], tdel, trise, tfall );
      V(vd5) <+ transition( vd[5], tdel, trise, tfall );
      V(vd4) <+ transition( vd[4], tdel, trise, tfall );
      V(vd3) <+ transition( vd[3], tdel, trise, tfall );
      V(vd2) <+ transition( vd[2], tdel, trise, tfall );
      V(vd1) <+ transition( vd[1], tdel, trise, tfall );
      V(vd0) <+ transition( vd[0], tdel, trise, tfall );

`undef NUM_ADC_BITS
   end
endmodule
